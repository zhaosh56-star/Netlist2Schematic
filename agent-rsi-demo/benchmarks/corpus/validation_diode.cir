.model DM D
V1 in 0 1
R1 in out 1k
D1 out 0 DM
C1 out 0 1n
.end
