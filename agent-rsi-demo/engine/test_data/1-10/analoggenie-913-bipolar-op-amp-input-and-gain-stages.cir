.subckt dut VCC VEE VSS Vip Vim Vo
.model DIODE D(IS=1e-14 N=1)
C1 net3 Vo 10pF
D1 net2 VEE DIODE
I1 VCC Vo DC 300uA
IEE VCC net1 DC 20uA
XQ1 net2 Vip net1 sky130_fd_pr__pnp_05v5_W0p68L0p68 m=1
XQ2 net3 Vim net1 sky130_fd_pr__pnp_05v5_W0p68L0p68 m=1
XQ4 net3 net2 VEE VSS sky130_fd_pr__npn_05v5_W1p00L1p00 m=1
XQ5 VCC net3 net0 VSS sky130_fd_pr__npn_05v5_W1p00L1p00 m=1
XQ6 Vo net0 VEE VSS sky130_fd_pr__npn_05v5_W1p00L1p00 m=1
R1 net0 VEE 50kΩ
.ends dut
