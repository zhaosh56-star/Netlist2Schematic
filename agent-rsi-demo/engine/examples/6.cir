CN N VSS 1p
CNC NC VSS 10p
CP VDD P 1p
CPC VDD PC 10p
MN1 N N VSS VSS NMOS l=1u m=1 nf=1 w=160u
MN2 net3 N net1 VSS NMOS l=1u m=1 nf=1 w=640u
MN3 NC NC N VSS NMOS l=1u m=1 nf=1 w=160u
MN4 PC NC net3 VSS NMOS l=1u m=1 nf=1 w=160u
MN5 SU NC VSS VSS NMOS l=1u m=1 nf=1 w=10u
MN6 PC SU N VSS NMOS l=2u m=1 nf=1 w=1u
MP1 net2 P VDD VDD PMOS l=.5u m=1 nf=1 w=640u
MP2 P P VDD VDD PMOS l=.5u m=1 nf=1 w=640u
MP3 NC PC net2 VDD PMOS l=.5u m=1 nf=1 w=640u
MP4 PC PC P VDD PMOS l=.5u m=1 nf=1 w=640u
MP5 SU NC net0 VDD PMOS l=8u m=1 nf=1 w=1u
RLIM VDD net0 500meg
RS net1 VSS 532256.566593
.ends Dual_Cascode_Constant_gm_Bias_with_Bypass_Capacitors
